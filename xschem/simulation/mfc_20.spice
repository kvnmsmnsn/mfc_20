** sch_path: /home/ttuser/Mfcs/mfc_20/xschem/mfc_20.sch
.subckt mfc_20 gate sbd
*.PININFO gate:I sbd:O
XM2 sbd gate sbd sbd sky130_fd_pr__nfet_01v8 L=0.6 W=0.42 nf=1 m=1
.ends
.end
